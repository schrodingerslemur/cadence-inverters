ADE simulation setup
Run mode: Single Run, Sweeps and Corners
Tests:
  project2_new_osc_5_tb_1: project2_new/osc_5_tb/schematic, simulator spectre
