ADE simulation setup
Run mode: Single Run, Sweeps and Corners
Tests:
  project2_new_osc_3_tb_1: project2_new/osc_3_tb/schematic, simulator spectre
