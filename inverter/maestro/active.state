ADE simulation setup
Test project1_inverter_1: project1/inverter/schematic, simulator spectre
  Models: /afs/ece.cmu.edu/class/ece320/F26/gpdk045_v_6_0/models/spectre/gpdk045.scs[tt], /afs/ece.cmu.edu/class/ece320/F26/cmosedu_models.txt
  Temperature: 27
  Analysis dc: (saves the operating point)
  Output OP("/PM0" "betaeff")
  Output OP("/PM0" "vth")
  Output OP("/PM0" "vds")
  Output OP("/PM0" "ids")
  Output (2.2 * abs((OP("/PM0" "vds") / OP("/PM0" "ids"))) * (OP("/PM0" "cdd") + OP("/NM0" "cdd") + OP("/M_next" "cgg")))
  Output OP("/PM0" "ron")
Run mode: Single Run, Sweeps and Corners
