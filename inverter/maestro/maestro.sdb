ADE simulation setup
Run mode: Single Run, Sweeps and Corners
Tests:
  project1_inverter_1: project1/inverter/schematic, simulator spectre
