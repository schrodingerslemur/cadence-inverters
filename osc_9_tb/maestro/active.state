ADE simulation setup
Test project2_new_osc_9_tb_1: project2_new/osc_9_tb/schematic, simulator spectre
  Models: /afs/ece.cmu.edu/class/ece320/F26/gpdk045_v_6_0/models/spectre/gpdk045.scs[tt], /afs/ece.cmu.edu/class/ece320/F26/cmosedu_models.txt
  Temperature: 27
  Initial conditions: /net1 = 1
  Analysis tran: stop=2n
  Signals: /net1
Run mode: Single Run, Sweeps and Corners
