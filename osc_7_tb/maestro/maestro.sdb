ADE simulation setup
Run mode: Single Run, Sweeps and Corners
Tests:
  project2_new_osc_7_tb_1: project2_new/osc_7_tb/schematic, simulator spectre
